ADE simulation setup
Test FA24SP25Analog_testbench_break_before_make_1: FA24SP25Analog/testbench_break_before_make/schematic, simulator spectre
  Models: /home/cx237/SKY130_PDK/sky130_release/libs/sky130_fd_pr_main/../../models/sky130.lib.spice[tt]
  Temperature: 27
  Stimulus VDD!: voltage dc dc=1.8 srcType=dc
  Stimulus VSS!: voltage dc dc=0 srcType=dc
  Stimulus CLK: voltage pulse val0=0 val1=1.8 period=20n rise=100p fall=100p width=10n srcType=pulse
  Analysis tran: stop=200n errpreset=conservative
  Signals: /P1, /P2
Test FA24SP25Analog_testbench_break_before_make_extracted: FA24SP25Analog/testbench_break_before_make/schematic, simulator spectre
  Models: /home/cx237/SKY130_PDK/sky130_release/libs/sky130_fd_pr_main/../../models/sky130.lib.spice[tt]
  Temperature: 27
  Stimulus VDD!: voltage dc dc=1.8 srcType=dc
  Stimulus VSS!: voltage dc dc=0 srcType=dc
  Stimulus CLK: voltage pulse val0=0 val1=1.8 period=20n rise=100p fall=100p width=10n srcType=pulse
  Analysis tran: stop=200n errpreset=conservative
  Signals: /P1, /P2, /CLK, /I0/net12, /I0/net1
Test FA24SP25Analog_testbench_break_before_make: FA24SP25Analog/testbench_break_before_make/schematic, simulator spectre
  Models: /home/cx237/SKY130_PDK/sky130_release/libs/sky130_fd_pr_main/../../models/sky130.lib.spice[tt]
  Temperature: 27
  Stimulus VDD!: voltage dc dc=1.8 srcType=dc
  Stimulus VSS!: voltage dc dc=0 srcType=dc
  Stimulus CLK: voltage pulse val0=0 val1=1.8 period=20n rise=100p fall=100p width=10n srcType=pulse
  Analysis tran: stop=200n errpreset=conservative
  Signals: /P1, /P2, /CLK
