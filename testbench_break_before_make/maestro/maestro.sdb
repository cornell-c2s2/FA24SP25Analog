ADE simulation setup
Run mode: Single Run, Sweeps and Corners
Tests:
  FA24SP25Analog_testbench_break_before_make_extracted: FA24SP25Analog/testbench_break_before_make/schematic, simulator spectre
  FA24SP25Analog_testbench_break_before_make: FA24SP25Analog/testbench_break_before_make/schematic, simulator spectre
