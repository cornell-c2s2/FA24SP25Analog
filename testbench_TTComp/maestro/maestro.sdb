ADE simulation setup
Run mode: Monte Carlo Sampling
Tests:
  FA24SP25Analog_testbench_TTComp_1: FA24SP25Analog/testbench_TTComp/schematic, simulator spectre
    Variables: diffpairnf = 1; diffpairmult = 1; diffwid = 6.75u; difflen = 2.25u; length = 500n
    Outputs: clip(VT("/outQ") 4e-09 5e-06 ?interpolate nil); intersect(clip(VT("/outQ") 4e-09 5e-06 ?interpolate nil) VT("/VINPC")); clip(VT("/outQ") 1e-08 5e-06 ?interpolate nil); intersect(clip(VT("/outQ") 1e-08 5e-06 ?interpolate nil) VT("/VINPC")); intersect(clip(VT("/outQ") 1e-07 5e-06 ?interpolate nil) VT("/VINPC"))
Global variables:
  diffpairnf = 4
  diffpairmult = 1
  diffwid = 4.5u
  difflen = 1.5u
  pfetlen = 150n 1u
  fetlen = 150n
  length = 150n
Device parameters (all switched off):
  FA24SP25Analog/triple_tail_comparator/schematic/NM6.fw = 2.66667 * NM7/fw@FA24SP25Analog/triple_tail_comparator/schematic
  FA24SP25Analog/triple_tail_comparator/schematic/NM6.l = NM5/l@FA24SP25Analog/triple_tail_comparator/schematic
  FA24SP25Analog/triple_tail_comparator/schematic/NM5.fw = 2.66667 * NM7/fw@FA24SP25Analog/triple_tail_comparator/schematic
  FA24SP25Analog/triple_tail_comparator/schematic/NM5.l = 500n
  FA24SP25Analog/triple_tail_comparator/schematic/PM4.fw = 4.44444 * NM7/fw@FA24SP25Analog/triple_tail_comparator/schematic
  FA24SP25Analog/triple_tail_comparator/schematic/PM4.l = NM5/l@FA24SP25Analog/triple_tail_comparator/schematic
  FA24SP25Analog/triple_tail_comparator/schematic/PM3.fw = 4.44444 * NM7/fw@FA24SP25Analog/triple_tail_comparator/schematic
  FA24SP25Analog/triple_tail_comparator/schematic/PM3.l = NM5/l@FA24SP25Analog/triple_tail_comparator/schematic
  FA24SP25Analog/triple_tail_comparator/schematic/PM5.fw = 4.44444 * NM7/fw@FA24SP25Analog/triple_tail_comparator/schematic
  FA24SP25Analog/triple_tail_comparator/schematic/PM5.l = NM5/l@FA24SP25Analog/triple_tail_comparator/schematic
  FA24SP25Analog/triple_tail_comparator/schematic/PM6.fw = 2 * NM7/fw@FA24SP25Analog/triple_tail_comparator/schematic
  FA24SP25Analog/triple_tail_comparator/schematic/PM6.l = NM5/l@FA24SP25Analog/triple_tail_comparator/schematic
  FA24SP25Analog/triple_tail_comparator/schematic/PM7.fw = 2 * NM7/fw@FA24SP25Analog/triple_tail_comparator/schematic
  FA24SP25Analog/triple_tail_comparator/schematic/PM7.l = NM5/l@FA24SP25Analog/triple_tail_comparator/schematic
  FA24SP25Analog/triple_tail_comparator/schematic/PM8.fw = 4.44444 * NM7/fw@FA24SP25Analog/triple_tail_comparator/schematic
  FA24SP25Analog/triple_tail_comparator/schematic/PM8.l = NM5/l@FA24SP25Analog/triple_tail_comparator/schematic
  FA24SP25Analog/triple_tail_comparator/schematic/NM8.fw = NM7/fw@FA24SP25Analog/triple_tail_comparator/schematic
  FA24SP25Analog/triple_tail_comparator/schematic/NM8.l = NM5/l@FA24SP25Analog/triple_tail_comparator/schematic
  FA24SP25Analog/triple_tail_comparator/schematic/NM7.fw = 1.5u
  FA24SP25Analog/triple_tail_comparator/schematic/NM7.l = NM5/l@FA24SP25Analog/triple_tail_comparator/schematic
Monte Carlo Sampling options: ignoremode=default, mismatchvary=Gaussian, sssnumpoints=7000, mismatchscale=1.0, processscale=1.0, pointsPerJobPolicy=Group automatically, maxPointsPerJob=10, reliabilitymode=singlestress, wcdinitialpoints=200, mcnumpoints=200, yeyistostart=3.0, mcSigmaTarget=3, yeiterations=10, processvary=Gaussian, yeexpectedyield=3, mcmethod=all, yeusehistorymc=0, yeuseautomcsamples=1, yecreatecorners=0, mcdistandscalingmismatchenable=0, parasiticanalysis=0, mcFilterPluginEnabled=0, haveyeyieldtostart=1, yeusevarreduction=1, mcdistandscalingprocessenable=0
