ADE simulation setup
Run mode: Monte Carlo Sampling
Tests:
  FA24SP25Analog_testbench_TTComp_1: FA24SP25Analog/testbench_TTComp/schematic, simulator spectre
    Variables: diffpairnf = 6
Monte Carlo Sampling options: ignoremode=default, mismatchvary=Gaussian, sssnumpoints=7000, mismatchscale=1.0, processscale=1.0, pointsPerJobPolicy=Group automatically, maxPointsPerJob=10, reliabilitymode=singlestress, wcdinitialpoints=200, mcnumpoints=100, yeyistostart=3.0, mcSigmaTarget=3, yeiterations=10, processvary=Gaussian, yeexpectedyield=3, mcmethod=global, yeusehistorymc=0, yeuseautomcsamples=1, yecreatecorners=0, mcdistandscalingmismatchenable=0, parasiticanalysis=0, mcFilterPluginEnabled=0, haveyeyieldtostart=1, yeusevarreduction=1, mcdistandscalingprocessenable=0
