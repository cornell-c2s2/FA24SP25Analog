ADE simulation setup
Test FA24SP25Analog_testbench_TTComp_1: FA24SP25Analog/testbench_TTComp/schematic, simulator spectre
  Models: /home/cx237/SKY130_PDK/sky130_release/models/parameters/critical.spice, /home/cx237/SKY130_PDK/sky130_release/models/parameters/montecarlo.spice
  Variables: diffpairnf = 4; diffpairmult = 1; diffwid = 6.75u; difflen = 2.25u; length = 500n
  Temperature: 27
  Simulator options: additionalArgs=soft_bin=allmodels
  Stimulus VDD!: voltage dc dc=1.8 srcType=dc
  Stimulus VSS!: voltage dc dc=0 srcType=dc
  Stimulus VINPC: voltage pwl dc=1.8 pwlfilter=  tvpairs=12 t1=0 v1=950m t2=25n v2=950m t3=26n v3=875m t4=50n v4=875m t5=51n v5=912m t6=75n v6=912m t7=76n v7=894m t8=100n v8=894m t9=101n v9=902m t10=125n v10=902m t11=126n v11=899m t12=150n v12=899m v13=0 v14=0 v15=0 v16=0 v17=0 v18=0 v19=0 v20=0 v21=0 v22=0 v23=0 v24=0 v25=0 v26=0 v27=0 v28=0 v29=0 v30=0 v31=0 v32=0 v33=0 v34=0 v35=0 v36=0 v37=0 v38=0 v39=0 v40=0 v41=0 v42=0 v43=0 v44=0 v45=0 v46=0 v47=0 v48=0 v49=0 v50=0 srcType=pwl
  Stimulus VINNC: voltage dc dc=900.0m srcType=dc
  Stimulus CLK: voltage pulse dc=0 val0=0 val1=1.8 period=25n delay=10n rise=300p fall=300p width=12.5n srcType=pulse
  Analysis tran: stop=150n errpreset=conservative
  Output clip(VT("/outQ") 1e-08 5e-06 ?interpolate nil) (unticked)
  Output intersect(clip(VT("/outQ") 1e-08 5e-06 ?interpolate nil) VT("/VINPC")) (unticked)
  Signals: /outQ, /outQN, /VINPC, /CLK, /VOUTP, /VOUTN, /net5, /net1, /VINNC
Run mode: Single Run, Sweeps and Corners
Global variables:
  diffpairnf = 4
  diffpairmult = 1
  diffwid = 4.5u
  difflen = 1.5u
  pfetlen = 150n 1u
  fetlen = 150n
  length = 150n
Device parameters (all switched off):
  FA24SP25Analog/triple_tail_comparator/schematic/NM6.fw = 2.66667 * NM7/fw@FA24SP25Analog/triple_tail_comparator/schematic
  FA24SP25Analog/triple_tail_comparator/schematic/NM6.l = NM5/l@FA24SP25Analog/triple_tail_comparator/schematic
  FA24SP25Analog/triple_tail_comparator/schematic/NM5.fw = 2.66667 * NM7/fw@FA24SP25Analog/triple_tail_comparator/schematic
  FA24SP25Analog/triple_tail_comparator/schematic/NM5.l = 500n
  FA24SP25Analog/triple_tail_comparator/schematic/PM4.fw = 4.44444 * NM7/fw@FA24SP25Analog/triple_tail_comparator/schematic
  FA24SP25Analog/triple_tail_comparator/schematic/PM4.l = NM5/l@FA24SP25Analog/triple_tail_comparator/schematic
  FA24SP25Analog/triple_tail_comparator/schematic/PM3.fw = 4.44444 * NM7/fw@FA24SP25Analog/triple_tail_comparator/schematic
  FA24SP25Analog/triple_tail_comparator/schematic/PM3.l = NM5/l@FA24SP25Analog/triple_tail_comparator/schematic
  FA24SP25Analog/triple_tail_comparator/schematic/PM5.fw = 4.44444 * NM7/fw@FA24SP25Analog/triple_tail_comparator/schematic
  FA24SP25Analog/triple_tail_comparator/schematic/PM5.l = NM5/l@FA24SP25Analog/triple_tail_comparator/schematic
  FA24SP25Analog/triple_tail_comparator/schematic/PM6.fw = 2 * NM7/fw@FA24SP25Analog/triple_tail_comparator/schematic
  FA24SP25Analog/triple_tail_comparator/schematic/PM6.l = NM5/l@FA24SP25Analog/triple_tail_comparator/schematic
  FA24SP25Analog/triple_tail_comparator/schematic/PM7.fw = 2 * NM7/fw@FA24SP25Analog/triple_tail_comparator/schematic
  FA24SP25Analog/triple_tail_comparator/schematic/PM7.l = NM5/l@FA24SP25Analog/triple_tail_comparator/schematic
  FA24SP25Analog/triple_tail_comparator/schematic/PM8.fw = 4.44444 * NM7/fw@FA24SP25Analog/triple_tail_comparator/schematic
  FA24SP25Analog/triple_tail_comparator/schematic/PM8.l = NM5/l@FA24SP25Analog/triple_tail_comparator/schematic
  FA24SP25Analog/triple_tail_comparator/schematic/NM8.fw = NM7/fw@FA24SP25Analog/triple_tail_comparator/schematic
  FA24SP25Analog/triple_tail_comparator/schematic/NM8.l = NM5/l@FA24SP25Analog/triple_tail_comparator/schematic
  FA24SP25Analog/triple_tail_comparator/schematic/NM7.fw = 1.5u
  FA24SP25Analog/triple_tail_comparator/schematic/NM7.l = NM5/l@FA24SP25Analog/triple_tail_comparator/schematic
Corners:
  Stat_seq_6 (off): monteCarlo::param::donominal=0; monteCarlo::param::ignoreFlag=0; monteCarlo::param::ignoreMode="default"; monteCarlo::param::instances="FA24SP25Analog_testbench_TTComp_1%/I5/NM2, /I5/NM3, /I5/NM5, /I5/NM6, /I5/PM3, /I5/PM4, /I5/PM5, /I5/PM8%Schematic%Schematic#"; monteCarlo::param::samplingMode="lds"; monteCarlo::param::saveAllPlots=1; monteCarlo::param::saveMismatch=0; monteCarlo::param::saveProcess=0; monteCarlo::param::seed="12345"; monteCarlo::param::sequence=6; monteCarlo::param::totalPoints=200; monteCarlo::param::type="all"
Setup values for test FA24SP25Analog_testbench_TTComp_1: diffpairnf = 1
