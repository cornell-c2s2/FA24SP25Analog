ADE simulation setup
Run mode: Single Run, Sweeps and Corners
Tests:
  FA24SP25Analog_triple_tail_comparator_1: FA24SP25Analog/triple_tail_comparator/schematic, simulator spectre
    Variables: diffpairnf = 2 5 10
