ADE simulation setup
Test FA24SP25Analog_non-overlap-clk_1: FA24SP25Analog/non-overlap-clk/schematic, simulator spectre
  Models: /home/dgk64/SKY130_PDK/sky130_release/libs/sky130_fd_pr_main/../../models/sky130.lib.spice[tt]
  Temperature: 27
  Stimulus CLK: voltage pulse dc=0 val0=0 val1=1.8 period=40n delay=0 rise=500.0p fall=500.0p width=19.5n srcType=pulse
  Stimulus VDD!: voltage dc dc=1.8 srcType=dc
  Stimulus VSS!: voltage dc dc=0 srcType=dc
  Analysis tran: stop=400n
  Signals: /P1, /P2, /CLK
Run mode: Single Run, Sweeps and Corners
