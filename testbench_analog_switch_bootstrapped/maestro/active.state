ADE simulation setup
Test FA24SP25Analog_testbench_analog_switch_bootstrapped_1: FA24SP25Analog/testbench_analog_switch_bootstrapped/schematic, simulator spectre
  Models: /home/dgk64/SKY130_PDK/sky130_release/libs/sky130_fd_pr_main/../../models/sky130.lib.spice[tt]
  Temperature: 27
  Stimulus CLK: voltage pulse dc=0 val0=0 val1=1.8 period=100n delay=0 rise=1n fall=1n width=49n srcType=pulse
  Stimulus VIN: voltage sin dc=0 mag=900.0m delay=0 sinedc=900.0m freq=1M filenums=none srcType=sine
  Stimulus VDD!: voltage dc dc=1.8 srcType=dc
  Stimulus VSS!: voltage dc dc=0 srcType=dc
  Analysis tran: stop=1u
  Signals: /CLK, /VIN, /VOUT
Run mode: Single Run, Sweeps and Corners
