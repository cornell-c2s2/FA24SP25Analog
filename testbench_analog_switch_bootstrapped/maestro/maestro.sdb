ADE simulation setup
Run mode: Single Run, Sweeps and Corners
Tests:
  FA24SP25Analog_testbench_analog_switch_bootstrapped_1: FA24SP25Analog/testbench_analog_switch_bootstrapped/schematic, simulator spectre
