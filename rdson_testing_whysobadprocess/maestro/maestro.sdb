ADE simulation setup
Run mode: Single Run, Sweeps and Corners
Tests:
  FA24SP25Analog_rdson_testing_whysobadprocess_1: FA24SP25Analog/rdson_testing_whysobadprocess/schematic, simulator spectre
    Variables: VGS = 0
