ADE simulation setup
Test FA24SP25Analog_rdson_testing_whysobadprocess_1: FA24SP25Analog/rdson_testing_whysobadprocess/schematic, simulator spectre
  Models: /home/dgk64/SKY130_PDK/sky130_release/libs/sky130_fd_pr_main/../../models/sky130.lib.spice[tt]
  Variables: VGS = 0
  Temperature: 27
  Analysis dc: sweep VGS start=0 stop=5 lin=101
  Signals: /net5, /NM0/D (terminal), /net6, /NM1/D (terminal), /net9, /NM2/D (terminal)
Run mode: Single Run, Sweeps and Corners
