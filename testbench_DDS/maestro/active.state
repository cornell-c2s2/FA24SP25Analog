ADE simulation setup
Test FA24SP25Analog_testbench_DDS_1: FA24SP25Analog/testbench_DDS/config, simulator ams
  Models: /home/dgk64/SKY130_PDK/sky130_release/models/sky130.lib.spice[tt]
  Temperature: 27
  Analysis tran: stop=200u errpreset=conservative
  Signals: /VOUT, /VSQR, /ctrl<11:0>
Run mode: Single Run, Sweeps and Corners
