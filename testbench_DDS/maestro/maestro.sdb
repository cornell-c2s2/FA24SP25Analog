ADE simulation setup
Run mode: Single Run, Sweeps and Corners
Tests:
  FA24SP25Analog_testbench_DDS_1: FA24SP25Analog/testbench_DDS/config, simulator ams
    Outputs: /ctrl<9:0>
