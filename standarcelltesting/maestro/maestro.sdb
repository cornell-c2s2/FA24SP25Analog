ADE simulation setup
Run mode: Single Run, Sweeps and Corners
Tests:
  FA24SP25Analog_standarcelltesting_1: FA24SP25Analog/standarcelltesting/schematic, simulator spectre
