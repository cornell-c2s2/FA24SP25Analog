ADE simulation setup
Test FA24SP25Analog_standarcelltesting_1: FA24SP25Analog/standarcelltesting/schematic, simulator spectre
  Models: /home/dgk64/SKY130_PDK/sky130_release/libs/sky130_fd_pr_main/../../models/sky130.lib.spice[tt]
  Temperature: 27
Run mode: Single Run, Sweeps and Corners
