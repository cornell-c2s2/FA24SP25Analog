ADE simulation setup
Test FA24SP25Analog_testbench_FSM_sub_1: FA24SP25Analog/testbench_FSM_sub/config, simulator ams
  Temperature: 27
  Stimulus CLK: voltage pulse dc=1.8 val0=0 val1=1.8 period=20u delay=0 rise=100.0p fall=100.0p width=9.9u srcType=pulse
  Analysis tran: stop=200u errpreset=conservative
  Output a2d_/CLK = awvAnalog2Digital(VT("/CLK") nil nil 0.9 nil "centre")
  Output a2d_/ENABLE = awvAnalog2Digital(VT("/ENABLE") nil nil 0.9 nil "centre")
  Output a2d_/RESET = awvAnalog2Digital(VT("/RESET") nil nil 0.9 nil "centre")
  Output a2d_/VCOMP = awvAnalog2Digital(VT("/VCOMP") nil nil 0.9 nil "centre")
  Output OUT = awvCreateBus("OUT" list(awvAnalog2Digital(VT("/OUT<1>") nil nil 0.9 nil "centre") awvAnalog2Digital(VT("/OUT<0>") nil nil 0.9 nil "centre")) "Binary")
  Signals: /CLK, /VCOMP, /ENABLE, /RESET, /OUT<1,0>, /OUT<1>, /OUT<0>
Run mode: Single Run, Sweeps and Corners
