ADE simulation setup
Run mode: Single Run, Sweeps and Corners
Tests:
  FA24SP25Analog_testbench_FSM_sub_1: FA24SP25Analog/testbench_FSM_sub/config, simulator ams
