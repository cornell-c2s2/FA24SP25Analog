ADE simulation setup
Test FA24SP25Analog_testbench_comp_switch_tgate_4_1: FA24SP25Analog/testbench_comp_switch_tgate_4/schematic, simulator spectre
  Models: /home/art227/SKY130_PDK/sky130_release/libs/sky130_fd_pr_main/../../models/sky130.lib.spice[tt]
  Temperature: 27
  Stimulus VDD: voltage dc dc=1.8 srcType=dc
  Analysis tran: stop=200n
  Signals: /net5, /net1, /VOUT, /net2
Run mode: Single Run, Sweeps and Corners
