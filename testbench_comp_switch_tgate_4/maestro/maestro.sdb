ADE simulation setup
Run mode: Single Run, Sweeps and Corners
Tests:
  FA24SP25Analog_testbench_comp_switch_tgate_4_1: FA24SP25Analog/testbench_comp_switch_tgate_4/schematic, simulator spectre
