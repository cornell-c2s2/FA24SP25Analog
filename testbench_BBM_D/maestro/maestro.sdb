ADE simulation setup
Run mode: Single Run, Sweeps and Corners
Tests:
  FA24SP25Analog_testbench_BBM_D_1: FA24SP25Analog/testbench_BBM_D/schematic, simulator spectre
