ADE simulation setup
Test FA24SP25Analog_testbench_BBM_D_1: FA24SP25Analog/testbench_BBM_D/schematic, simulator spectre
  Models: /home/art227/SKY130_PDK/sky130_release/libs/sky130_fd_pr_main/../../models/sky130.lib.spice[tt]
  Temperature: 27
  Stimulus VDD!: voltage dc dc=1.8 srcType=dc
  Stimulus VSS!: voltage dc dc=0 srcType=dc
  Stimulus IN<0>: voltage pulse dc=1.8 val0=0 val1=1.8 period=150n delay=50n rise=100.0p fall=100.0p width=49.9n srcType=pulse
  Stimulus IN<1>: voltage pulse dc=1.8 val0=0 val1=1.8 period=150n delay=100n rise=100.0p fall=100.0p width=49.9n srcType=pulse
  Stimulus IN<2>: voltage pulse dc=1.8 val0=0 val1=1.8 period=150n delay=150n rise=100.0p fall=100.0p width=49.9n srcType=pulse
  Analysis tran: stop=275n errpreset=conservative
  Signals: /OUT<0>, /OUT<1>, /OUT<2>, /IN<0>, /IN<1>, /IN<2>
Run mode: Single Run, Sweeps and Corners
