ADE simulation setup
Run mode: Single Run, Sweeps and Corners
Tests:
  FA24SP25Analog_non-overlap-clk_1: FA24SP25Analog/break_before_make/schematic, simulator spectre
