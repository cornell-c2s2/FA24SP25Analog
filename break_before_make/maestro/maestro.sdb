ADE simulation setup
Run mode: Single Run, Sweeps and Corners
Tests:
  FA24SP25Analog_break_before_make_1: FA24SP25Analog/break_before_make/schematic, simulator spectre
  FA24SP25Analog_break_before_make_2: FA24SP25Analog/break_before_make/schematic, simulator spectre
