ADE simulation setup
Test FA24SP25Analog_break_before_make_1: FA24SP25Analog/break_before_make/schematic, simulator spectre
  Models: /home/cx237/SKY130_PDK/sky130_release/libs/sky130_fd_pr_main/../../models/sky130.lib.spice[tt]
  Temperature: 27
  Stimulus CLK: voltage pulse val0=0 val1=1.8 period=20n rise=100p fall=100p srcType=pulse
  Stimulus VDD!: voltage dc dc=1.8 srcType=dc
  Stimulus VSS!: voltage dc dc=0 srcType=dc
  Signals: /P1, /P2, /CLK
Test FA24SP25Analog_break_before_make_2: FA24SP25Analog/break_before_make/schematic, simulator spectre
  Models: /home/cx237/SKY130_PDK/sky130_release/libs/sky130_fd_pr_main/../../models/sky130.lib.spice[tt]
  Temperature: 27
Run mode: Single Run, Sweeps and Corners
