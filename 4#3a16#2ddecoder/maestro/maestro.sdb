ADE simulation setup
Run mode: Single Run, Sweeps and Corners
Tests:
  c2s2Lib_decoder_1: c2s2Lib/4:16-decoder/schematic, simulator spectre
