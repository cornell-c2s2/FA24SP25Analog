ADE simulation setup
Test c2s2Lib_decoder_1: c2s2Lib/4:16-decoder/schematic, simulator spectre
  Models: /home/ar933/SKY130_PDK/sky130_release/libs/sky130_fd_pr_main/../../models/sky130.lib.spice[tt]
  Temperature: 27
  Stimulus input1: voltage pulse val0=0 val1=1.8 period=2.5u delay=0 rise=25n fall=25n width=1.25u srcType=pulse
  Stimulus input2: voltage pulse val0=0 val1=1.8 period=5u delay=0 rise=25n fall=25n width=2.5u srcType=pulse
  Stimulus input3: voltage pulse val0=0 val1=1.8 period=10u delay=0 rise=25n fall=25n width=5u srcType=pulse
  Stimulus input0: voltage pulse val0=0 val1=1.8 period=1.25u delay=0 rise=25n fall=25n width=625.000n srcType=pulse
  Stimulus VSS!: voltage dc dc=0 srcType=dc
  Stimulus VDD!: voltage dc dc=1.8 srcType=dc
  Analysis tran: stop=10u
  Signals: /input1, /input0, /input2, /input3, /out1, /out2, /out3, /out4, /out5, /out6, /out7, /out8, /out9, /out10, /out11, /out12, /out13, /out14, /out15, /out16
Run mode: Single Run, Sweeps and Corners
