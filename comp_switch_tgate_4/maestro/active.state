ADE simulation setup
Test FA24SP25Analog_comp_switch_tgate_1: FA24SP25Analog/comp_switch_tgate/schematic, simulator spectre
  Models: /home/dgk64/SKY130_PDK/sky130_release/libs/sky130_fd_pr_main/../../models/sky130.lib.spice[tt]
  Variables: mult = 15
  Temperature: 27
  Stimulus VSS!: voltage dc dc=0 srcType=dc
  Stimulus VDD!: voltage dc dc=1.8 srcType=dc
  Stimulus CLK: voltage pulse dc=0 val0=0 val1=1.8 period=25n delay=0 rise=1n fall=1n width=11.5n srcType=pulse
  Stimulus VIN: voltage pwl dc=0 delay=0 pwlfilter=  tvpairs=2 t1=0 v1=900.0m t2=250n v2=900.0m v3=0 v4=0 v5=0 v6=0 v7=0 v8=0 v9=0 v10=0 v11=0 v12=0 v13=0 v14=0 v15=0 v16=0 v17=0 v18=0 v19=0 v20=0 v21=0 v22=0 v23=0 v24=0 v25=0 v26=0 v27=0 v28=0 v29=0 v30=0 v31=0 v32=0 v33=0 v34=0 v35=0 v36=0 v37=0 v38=0 v39=0 v40=0 v41=0 v42=0 v43=0 v44=0 v45=0 v46=0 v47=0 v48=0 v49=0 v50=0 srcType=pwl
  Analysis tran: stop=250n errpreset=conservative
  Output "(VT(\"/VIN\")-VT(\"/VOUT\"))/IT(\"/R0/PLUS\")" = ((VT("/VIN") - VT("/VOUT")) / IT("/R0/PLUS"))
  Signals: /CLK, /CLKN, /VIN, /VOUT, /R0/PLUS (terminal)
Run mode: Single Run, Sweeps and Corners
