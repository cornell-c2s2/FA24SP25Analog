ADE simulation setup
Run mode: Single Run, Sweeps and Corners
Tests:
  FA24SP25Analog_comp_switch_tgate_1: FA24SP25Analog/comp_switch_tgate/schematic, simulator spectre
    Variables: mult = 15
