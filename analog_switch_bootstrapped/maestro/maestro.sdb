ADE simulation setup
Run mode: Single Run, Sweeps and Corners
Tests:
  FA24SP25Analog_analog_switch_bootstrapped_1: FA24SP25Analog/analog_switch_bootstrapped/schematic, simulator spectre
    Variables: nf = 6
