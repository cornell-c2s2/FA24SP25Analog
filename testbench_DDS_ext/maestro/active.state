ADE simulation setup
Test FA24SP25Analog_testbench_DDS_ext_1: FA24SP25Analog/testbench_DDS_ext/schematic, simulator spectre
  Models: /home/dgk64/SKY130_PDK/sky130_release/libs/sky130_fd_pr_main/../../models/sky130.lib.spice[tt]
  Temperature: 27
  Files: vectors /home/dgk64/SKY130_PDK/FA24SP25Analog/CadenceVectors/DDS.vec
  Analysis tran: stop=40u errpreset=liberal
  Signals: /VOUT, /VSQR, /ctrl[0], /ramp_out<5>, /ramp_out<4>, /ramp_out<3>, /ramp_out<2>, /ramp_out<1>, /ramp_out<0>, /vdd, /CLK, /I12/X, /V2/PLUS (terminal)
Run mode: Single Run, Sweeps and Corners
