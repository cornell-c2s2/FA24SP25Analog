ADE simulation setup
Run mode: Single Run, Sweeps and Corners
Tests:
  FA24SP25Analog_safety_module_1: FA24SP25Analog/safety_module/config, simulator ams
    Outputs: "/IN<2:0>"
