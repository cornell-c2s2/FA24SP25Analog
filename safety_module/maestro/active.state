ADE simulation setup
Test FA24SP25Analog_safety_module_1: FA24SP25Analog/safety_module/config, simulator ams
  Models: /home/dgk64/SKY130_PDK/sky130_release/models/sky130.lib.spice[tt]
  Temperature: 27
  Stimulus VDD!: voltage dc dc=1.8 srcType=dc
  Stimulus VSS!: voltage dc dc=0 srcType=dc
  Analysis tran: stop=40n
  Output VIN = awvCreateBus("VIN" list(awvAnalog2Digital(VT("/IN<1>") nil nil 0.9 nil "centre") awvAnalog2Digital(VT("/IN<0>") nil nil 0.9 nil "centre")) "Binary")
  Output VBETW = awvCreateBus("VBETW" list(awvAnalog2Digital(VT("/net1<0>") nil nil 0.9 nil "centre") awvAnalog2Digital(VT("/net1<1>") nil nil 0.9 nil "centre") awvAnalog2Digital(VT("/net1<2>") nil nil 0.9 nil "centre")) "Binary")
  Output VOUT = awvCreateBus("VOUT" list(awvAnalog2Digital(VT("/OUT<2>") nil nil 0.9 nil "centre") awvAnalog2Digital(VT("/OUT<1>") nil nil 0.9 nil "centre") awvAnalog2Digital(VT("/OUT<0>") nil nil 0.9 nil "centre")) "Binary")
  Signals: /IN<1,0>, /net1<0:2>, /OUT<2:0>, /net1<0>, /net1<1>, /net1<2>
Run mode: Single Run, Sweeps and Corners
