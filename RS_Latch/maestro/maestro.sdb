ADE simulation setup
Run mode: Single Run, Sweeps and Corners
Tests:
  c2s2Lib_RS-Latch_1: c2s2Lib/RS-Latch/schematic, simulator spectre
