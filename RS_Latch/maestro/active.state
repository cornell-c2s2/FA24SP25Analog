ADE simulation setup
Test c2s2Lib_RS-Latch_1: c2s2Lib/RS-Latch/schematic, simulator spectre
  Models: /home/sa876/SKY130_PDK/sky130_release/libs/sky130_fd_pr_main/../../models/sky130.lib.spice[tt]
  Temperature: 27
  Analysis tran: stop=3n
  Signals: /QN, /Q, /S, /R
Run mode: Single Run, Sweeps and Corners
