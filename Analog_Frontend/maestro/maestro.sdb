ADE simulation setup
Run mode: Single Run, Sweeps and Corners
Tests:
  FA24SP25Analog_Analog_Frontend_1: FA24SP25Analog/Analog_Frontend/schematic, simulator spectre
