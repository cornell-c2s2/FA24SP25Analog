ADE simulation setup
Test FA24SP25Analog_triple_tail_comparator_1: FA24SP25Analog/triple_tail_comparator/schematic, simulator spectre
  Models: /home/cx237/SKY130_PDK/sky130_release/libs/sky130_fd_pr_main/../../models/sky130.lib.spice[tt]
  Variables: diffpairnf = 2
  Temperature: 27
  Stimulus VDD!: voltage dc dc=1.8 srcType=dc
  Stimulus VSS!: voltage dc dc=0 srcType=dc
  Analysis tran: stop=100u errpreset=conservative
  Signals: /VOUTP, /VOUTN, /CLK, /VINPR, /VINNR, /VINP, /VINN, /net2, /net1
