ADE simulation setup
Test FA24SP25Analog_mismatch_test_1: FA24SP25Analog/mismatch_test/schematic, simulator spectre
  Models: /home/cx237/SKY130_PDK/sky130_release/models/parameters/critical.spice, /home/cx237/SKY130_PDK/sky130_release/models/parameters/montecarlo.spice
  Temperature: 27
  Simulator options: additionalArgs=soft_bin=allmodels
  Stimulus VINN: voltage dc dc=900.0m srcType=dc
  Stimulus VINP: voltage pwl pwlfilter=  tvpairs=2 t1=0 v1=700m t2=20u v2=1.1 v3=0 v4=0 v5=0 v6=0 v7=0 v8=0 v9=0 v10=0 v11=0 v12=0 v13=0 v14=0 v15=0 v16=0 v17=0 v18=0 v19=0 v20=0 v21=0 v22=0 v23=0 v24=0 v25=0 v26=0 v27=0 v28=0 v29=0 v30=0 v31=0 v32=0 v33=0 v34=0 v35=0 v36=0 v37=0 v38=0 v39=0 v40=0 v41=0 v42=0 v43=0 v44=0 v45=0 v46=0 v47=0 v48=0 v49=0 v50=0 srcType=pwl
  Stimulus iout: current dc dc=10u srcType=dc
  Stimulus GND: voltage dc dc=0 srcType=dc
  Stimulus VDD: voltage dc dc=1.8 srcType=dc
  Analysis tran: stop=20u errpreset=conservative
  Output intersect(VT("/VOUTN") VT("/VINP"))
  Signals: /VOUTN, /VOUTP, /VINP, /VINN, /iout
Run mode: Monte Carlo Sampling
Monte Carlo Sampling options: ignoremode=default, mismatchvary=Gaussian, sssnumpoints=7000, mismatchscale=1.0, processscale=1.0, pointsPerJobPolicy=Group automatically, maxPointsPerJob=10, reliabilitymode=singlestress, wcdinitialpoints=200, mcnumpoints=500, yeyistostart=3.0, mcSigmaTarget=3, yeiterations=10, processvary=Gaussian, yeexpectedyield=3, mcmethod=all, yeusehistorymc=0, yeuseautomcsamples=1, yecreatecorners=0, mcdistandscalingmismatchenable=0, parasiticanalysis=0, mcFilterPluginEnabled=0, haveyeyieldtostart=1, yeusevarreduction=1, mcdistandscalingprocessenable=0
