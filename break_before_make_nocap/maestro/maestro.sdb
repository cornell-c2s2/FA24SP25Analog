ADE simulation setup
Run mode: Single Run, Sweeps and Corners
Tests:
  FA24SP25Analog_non-overlap-clk_1: FA24SP25Analog/break_before_make/schematic, simulator spectre
Corners:
  model folders: /home/cx237/SKY130_PDK/sky130_release/libs/sky130_fd_pr_main/../../models
  FF: sky130.lib.spice[ff]
  FS: sky130.lib.spice[fs]
  SS: sky130.lib.spice[ss]
  SF: sky130.lib.spice[sf]
