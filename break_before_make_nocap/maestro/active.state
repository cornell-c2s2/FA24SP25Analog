ADE simulation setup
Test FA24SP25Analog_non-overlap-clk_1: FA24SP25Analog/break_before_make/schematic, simulator spectre
  Models: /home/cx237/SKY130_PDK/sky130_release/libs/sky130_fd_pr_main/../../models/sky130.lib.spice[tt]
  Temperature: 27
  Stimulus CLK: voltage pulse dc=0 val0=0 val1=1.8 period=40n delay=0 rise=500.0p fall=500.0p width=19.5n srcType=pulse
  Analysis tran: stop=400n
  Signals: /P1, /P2, /CLK
Run mode: Single Run, Sweeps and Corners
Corners:
  model folders: /home/cx237/SKY130_PDK/sky130_release/libs/sky130_fd_pr_main/../../models
  FF: sky130.lib.spice[ff]
  FS: sky130.lib.spice[fs]
  SS: sky130.lib.spice[ss]
  SF: sky130.lib.spice[sf]
