ADE simulation setup
Test FA24SP25Analog_SAR_Top_1_1: FA24SP25Analog/SAR_Top/config, simulator ams
  Models: /home/cx237/SKY130_PDK/sky130_release/models/parameters/critical.spice, /home/cx237/SKY130_PDK/sky130_release/models/parameters/montecarlo.spice
  Temperature: 27
  Simulator options: additionalArgs=soft_bin=allmodels
  Stimulus VDD!: voltage dc dc=1.8 srcType=dc
  Stimulus VSS!: voltage dc dc=0 srcType=dc
  Stimulus CLK: voltage pulse dc=0 val0=0 val1=1.8 period=25n delay=0 rise=100.0p fall=100.0p width=12.4n srcType=pulse
  Stimulus VINP: voltage pwl dc=0 pwlfilter=  tvpairs=3 t1=0 v1=0 t2=2.5u v2=0 t3=2.51u v3=1.8 v4=0 v5=0 v6=0 v7=0 v8=0 v9=0 v10=0 v11=0 v12=0 v13=0 v14=0 v15=0 v16=0 v17=0 v18=0 v19=0 v20=0 v21=0 v22=0 v23=0 v24=0 v25=0 v26=0 v27=0 v28=0 v29=0 v30=0 v31=0 v32=0 v33=0 v34=0 v35=0 v36=0 v37=0 v38=0 v39=0 v40=0 v41=0 v42=0 v43=0 v44=0 v45=0 v46=0 v47=0 v48=0 v49=0 v50=0 srcType=pwl
  Stimulus VCM: voltage dc dc=900.0m srcType=dc
  Stimulus GLOBAL_RESET: voltage pwl dc=0 pwlfilter=  tvpairs=3 t1=0 v1=1.8 t2=30n v2=1.8 t3=31n v3=0 v4=0 v5=0 v6=0 v7=0 v8=0 v9=0 v10=0 v11=0 v12=0 v13=0 v14=0 v15=0 v16=0 v17=0 v18=0 v19=0 v20=0 v21=0 v22=0 v23=0 v24=0 v25=0 v26=0 v27=0 v28=0 v29=0 v30=0 v31=0 v32=0 v33=0 v34=0 v35=0 v36=0 v37=0 v38=0 v39=0 v40=0 v41=0 v42=0 v43=0 v44=0 v45=0 v46=0 v47=0 v48=0 v49=0 v50=0 srcType=pwl
  Stimulus VINN: voltage pwl dc=1.8 pwlfilter=  tvpairs=3 t1=0 v1=1.8 t2=2.5u v2=1.8 t3=2.51u v3=0 v4=0 v5=0 v6=0 v7=0 v8=0 v9=0 v10=0 v11=0 v12=0 v13=0 v14=0 v15=0 v16=0 v17=0 v18=0 v19=0 v20=0 v21=0 v22=0 v23=0 v24=0 v25=0 v26=0 v27=0 v28=0 v29=0 v30=0 v31=0 v32=0 v33=0 v34=0 v35=0 v36=0 v37=0 v38=0 v39=0 v40=0 v41=0 v42=0 v43=0 v44=0 v45=0 v46=0 v47=0 v48=0 v49=0 v50=0 srcType=pwl
  Stimulus FT: voltage dc dc=0 srcType=dc
  Analysis tran: stop=5u errpreset=conservative
  Output VOUT = awvCreateBus("VOUT" list(awvAnalog2Digital(VT("/VOUT<7>") nil nil 0.9 nil "centre") awvAnalog2Digital(VT("/VOUT<6>") nil nil 0.9 nil "centre") awvAnalog2Digital(VT("/VOUT<5>") nil nil 0.9 nil "centre") awvAnalog2Digital(VT("/VOUT<4>") nil nil 0.9 nil "centre") awvAnalog2Digital(VT("/VOUT<3>") nil nil 0.9 nil "centre") awvAnalog2Digital(VT("/VOUT<2>") nil nil 0.9 nil "centre") awvAnalog2Digital(VT("/VOUT<1>") nil nil 0.9 nil "centre") awvAnalog2Digital(VT("/VOUT<0>") nil nil 0.9 nil "centre")) "Unsigned Decimal")
  Signals: /VOUT<7:0>, /GLOBAL_RESET, /CLK, /VCOMP, /FSM_RESET, /SAR_RESET, /BBM_D_3<0,2,1>, /OUT<7:0>, /CDACP, /CDACN, /net241, /net209
Test FA24SP25Analog_SAR_Top_1: FA24SP25Analog/SAR_Top/config, simulator ams
  Models: /home/cx237/SKY130_PDK/sky130_release/models/parameters/critical.spice, /home/cx237/SKY130_PDK/sky130_release/models/parameters/montecarlo.spice
  Temperature: 27
  Simulator options: additionalArgs=soft_bin=allmodels
  Stimulus VDD!: voltage dc dc=1.8 srcType=dc
  Stimulus VSS!: voltage dc dc=0 srcType=dc
  Stimulus CLK: voltage pulse dc=0 val0=0 val1=1.8 period=25n delay=0 rise=100.0p fall=100.0p width=12.4n srcType=pulse
  Stimulus VINP: voltage pwl dc=0 pwlfilter=  tvpairs=3 t1=0 v1=0 t2=2.5u v2=0 t3=2.51u v3=1.8 v4=0 v5=0 v6=0 v7=0 v8=0 v9=0 v10=0 v11=0 v12=0 v13=0 v14=0 v15=0 v16=0 v17=0 v18=0 v19=0 v20=0 v21=0 v22=0 v23=0 v24=0 v25=0 v26=0 v27=0 v28=0 v29=0 v30=0 v31=0 v32=0 v33=0 v34=0 v35=0 v36=0 v37=0 v38=0 v39=0 v40=0 v41=0 v42=0 v43=0 v44=0 v45=0 v46=0 v47=0 v48=0 v49=0 v50=0 srcType=pwl
  Stimulus VCM: voltage dc dc=900.0m srcType=dc
  Stimulus GLOBAL_RESET: voltage pwl dc=0 pwlfilter=  tvpairs=3 t1=0 v1=1.8 t2=30n v2=1.8 t3=31n v3=0 v4=0 v5=0 v6=0 v7=0 v8=0 v9=0 v10=0 v11=0 v12=0 v13=0 v14=0 v15=0 v16=0 v17=0 v18=0 v19=0 v20=0 v21=0 v22=0 v23=0 v24=0 v25=0 v26=0 v27=0 v28=0 v29=0 v30=0 v31=0 v32=0 v33=0 v34=0 v35=0 v36=0 v37=0 v38=0 v39=0 v40=0 v41=0 v42=0 v43=0 v44=0 v45=0 v46=0 v47=0 v48=0 v49=0 v50=0 srcType=pwl
  Stimulus VINN: voltage pwl dc=1.8 pwlfilter=  tvpairs=3 t1=0 v1=1.8 t2=2.5u v2=1.8 t3=2.51u v3=0 v4=0 v5=0 v6=0 v7=0 v8=0 v9=0 v10=0 v11=0 v12=0 v13=0 v14=0 v15=0 v16=0 v17=0 v18=0 v19=0 v20=0 v21=0 v22=0 v23=0 v24=0 v25=0 v26=0 v27=0 v28=0 v29=0 v30=0 v31=0 v32=0 v33=0 v34=0 v35=0 v36=0 v37=0 v38=0 v39=0 v40=0 v41=0 v42=0 v43=0 v44=0 v45=0 v46=0 v47=0 v48=0 v49=0 v50=0 srcType=pwl
  Stimulus FT: voltage dc dc=1.8 srcType=dc
  Analysis tran: stop=5u errpreset=conservative
  Output VOUT = awvCreateBus("VOUT" list(awvAnalog2Digital(VT("/VOUT<7>") nil nil 0.9 nil "centre") awvAnalog2Digital(VT("/VOUT<6>") nil nil 0.9 nil "centre") awvAnalog2Digital(VT("/VOUT<5>") nil nil 0.9 nil "centre") awvAnalog2Digital(VT("/VOUT<4>") nil nil 0.9 nil "centre") awvAnalog2Digital(VT("/VOUT<3>") nil nil 0.9 nil "centre") awvAnalog2Digital(VT("/VOUT<2>") nil nil 0.9 nil "centre") awvAnalog2Digital(VT("/VOUT<1>") nil nil 0.9 nil "centre") awvAnalog2Digital(VT("/VOUT<0>") nil nil 0.9 nil "centre")) "Unsigned Decimal")
  Signals: /VOUT<7:0>, /GLOBAL_RESET, /CLK, /VCOMP, /FSM_RESET, /SAR_RESET, /BBM_D_3<0,2,1>, /OUT<7:0>, /CDACP, /CDACN, /net241, /net209, /net27, /net17
