ADE simulation setup
Run mode: Single Run, Sweeps and Corners
Tests:
  FA24SP25Analog_SAR_Top_1: FA24SP25Analog/SAR_Top/config, simulator ams
    Outputs: "/VOUT<5:0>"; "/VOUT<7:0>"; /OUT<7:0>; /VOUT<7:0>
  FA24SP25Analog_SAR_Top_1_1: FA24SP25Analog/SAR_Top/config, simulator ams
    Outputs: "/VOUT<5:0>"; "/VOUT<7:0>"; /OUT<7:0>; /VOUT<7:0>
Corners:
  model folders: /home/cx237/SKY130_PDK/sky130_release/models
  FF (off): sky130.lib.spice[ff]
  SS (off): sky130.lib.spice[ss]
  FS (off): sky130.lib.spice[fs]
  SF (off): sky130.lib.spice[sf]
