ADE simulation setup
Run mode: Single Run, Sweeps and Corners
Tests:
  FA24SP25Analog_SAR_Top_1: FA24SP25Analog/SAR_Top/config, simulator ams
    Outputs: "/VOUT<5:0>"; /VOUT<5:0>
