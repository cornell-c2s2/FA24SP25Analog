ADE simulation setup
Run mode: Single Run, Sweeps and Corners
Tests:
  FA24SP25Analog_SAR_Top_1: FA24SP25Analog/SAR_Top/config, simulator ams
    Outputs: "/VOUT<5:0>"; /VOUT<5:0>
Corners (all switched off):
  model folders: /home/cx237/SKY130_PDK/sky130_release/models
  FF: sky130.lib.spice[ff]
  SS: sky130.lib.spice[ss]
  FS: sky130.lib.spice[fs]
  SF: sky130.lib.spice[sf]
