ADE simulation setup
Run mode: Single Run, Sweeps and Corners
Tests:
  FA24SP25Analog_comp_switch_tgate_8_1: FA24SP25Analog/comp_switch_tgate_8/schematic, simulator spectre
