ADE simulation setup
Test FA24SP25Analog_comp_switch_tgate_8_1: FA24SP25Analog/comp_switch_tgate_8/schematic, simulator spectre
  Models: /home/dgk64/SKY130_PDK/sky130_release/libs/sky130_fd_pr_main/../../models/sky130.lib.spice[tt]
  Temperature: 27
  Stimulus VSS: voltage dc dc=0 srcType=dc
  Stimulus VIN: voltage sin dc=0 mag=900.0m ampl=900.0m sinephase=0 freq=10M filenums=none srcType=sine
  Stimulus VDD: voltage dc dc=1.8 srcType=dc
  Stimulus SW: voltage pulse dc=0 val0=0 val1=1.8 period=150n rise=100.0p fall=100.0p width=125n srcType=pulse
  Analysis tran: stop=250n errpreset=conservative
  Signals: /SW, /SWN, /VIN, /VOUT
Run mode: Single Run, Sweeps and Corners
